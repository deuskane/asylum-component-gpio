{
    name      : "GPIO",
    width     : 8,
    desc      : "CSR for General Purpose I/O"
    registers : [
        {
            name         : "data",
            address      : "x0",
	    alias_write  : "data_out",
            desc         : "data - with data_oe mask apply",
            swaccess     : "rw",
            hwaccess     : "rw",
	    hwext        : True
            fields: [
                {
                    name: "value",
                    bits: "7:0",
                    init: "d0",
                    desc: "Data with data_oe with mask apply"
                },
            ]
        },
        {
            name       : "data_oe",
            address    : "x1",
            desc       : "GPIO Direction",
            swaccess   : "rw",
            hwaccess   : "rw",
            fields: [
                {
                    name: "value",
                    bits: "7:0",
                    init: "d0",
                    desc: "GPIO Direction : 0 input, 1 output"
                },
            ]
        },
        {
            name       : "data_in",
            address    : "x2",
            desc       : "GPIO Input",
            swaccess   : "ro",
            hwaccess   : "wo",
            fields: [
                {
                    name: "value",
                    bits: "7:0",
                    init: "d0",
                    desc: "Input Data of GPIO"
                },
            ]
        },
        {
            name       : "data_out",
            address    : "x3",
	    desc       : "GPIO Output",
            swaccess   : "rw",
            hwaccess   : "ro",
            fields: [
                {
                    name: "value",
                    bits: "7:0",
                    init: "d0",
                    desc: "Output Data of GPIO"
                },
            ]
        },
    ]
}
